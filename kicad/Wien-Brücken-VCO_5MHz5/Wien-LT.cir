* /Users/mimeiners/Documents/courses/ans/sose2026/elie4/kicad/Wien-Brücken-VCO_5MHz5/Wien-LT.asc
* Generated by LTspice 26.0.2 for MacOS.
C1 N003 0 {C}
C2 va N002 {C}
R2 N003 0 {R}
R4 ve 0 1k2
R8 N004 ve 10k
R5 0 N005 20k
R7 P001 va 1k
R3 ve va 2k3
R1 N002 N003 {R}
R9 N001 Vstr 100k
R6 N006 Vstr 100k
D1 N005 P001 1N4148
C3 N005 0 1nF
D5 N003 N006 1SV305
D3 0 N006 1SV305
D2 va N001 1SV305
VCC- VCC- 0 -10V
VCC+ VCC+ 0 10V
Vstr Vstr 0 {Vstr}
X§U2 N003 ve VCC+ VCC- va LT1363 ;§pnba In+)In-)V+)V-)OUT
J1 N004 N005 0 J113
D4 N002 N001 1SV305
.model D D
.lib C:\users\crossover\AppData\Local\LTspice\lib\cmp\standard.dio
.model NJF NJF
.model PJF PJF
.lib C:\users\crossover\AppData\Local\LTspice\lib\cmp\standard.jft
.param R=1k
.param C=17pF
.param Vstr=2V
*.step param Vstr list 8 9 10 11 12 13 14 15 16
.ic V(va)=0.000000000001
.model 1SV305 D(IS=1e-14 RS=0.27 CJO=28p M=0.5 VJ=0.75)
.tran 1n 100u
* Library below included based on ModelFile attribute of instance X§U2 (C:\users\crossover\AppData\Local\LTspice\lib\sym\OpAmps\LT1363.asy)
.lib LT1363.sub
.backanno
.end
